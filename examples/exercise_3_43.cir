* Schaum Basic Circuit Analysis, Exercise 3.43.
* A 90 A current source feeds four parallel resistors.
I90 0 top 90
R5 top 0 5
R6 top 0 6
R12 top 0 12
R20 top 0 20
