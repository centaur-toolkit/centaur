* Schaum Basic Circuit Analysis, Exercise 3.24 / Fig. 3-11.
* Edep is a voltage-controlled voltage source:
* V(0, dep_top) = 4.5 * V(src, mid).
* Query I R4 for the reference current I and P Edep for dependent-source power.
V24 src 0 24
R4 src mid 4
R2 mid dep_top 2
Edep 0 dep_top src mid 4.5
