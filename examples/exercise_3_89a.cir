* Schaum Basic Circuit Analysis, Exercise 3.89(a) / Fig. 3-41.
* Find I through the load branch for RL = 0 ohm.
I28 0 left 28
R8 left 0 8
R6 left load 6
R20 load 0 20
Vload load 0 0
