* Schaum Basic Circuit Analysis, Exercise 3.78.
* A 15-mA source feeds 4-, 6-, 8-, and 12-kOhm resistors in parallel.
* Currents are in mA when resistance values are interpreted as kOhm.
I15 0 top 15
R4 top 0 4
R6 top 0 6
R8 top 0 8
R12 top 0 12
