* Thevenin seen at out relative to ground.
* Expected: Vth = Vin * R2 / (R1 + R2), Rth = R3 + (R1 || R2).
V1 in 0 Vin
R1 in tap R1
R2 tap 0 R2
R3 tap out R3
