* Schaum Basic Circuit Analysis, Exercise 3.45 / Fig. 3-21.
* Same circuit as Exercise 3.44; this exercise asks for I2 and I3 by current division.
I190 0 top 190
I50 top 0 50
I60 0 top 60
R6 top 0 (inv 6)
R12 0 top (inv 12)
R24 top 0 (inv 24)
R8 0 top (inv 8)
