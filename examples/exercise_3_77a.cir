* Schaum Basic Circuit Analysis, Exercise 3.77(a) / Fig. 3-34.
* Terminals a and b are open-circuited.
Rtop7 in top 7
Rbot8 0 bot 8
Rsh10 top bot 10
Rleft3 top a 3
Rleft5 a bot 5
Rright8 top b 8
Rright4 b bot 4
