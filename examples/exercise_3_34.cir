* Schaum Basic Circuit Analysis, Exercise 3.34.
* Fifty 200 ohm resistors connected in parallel between terminals a and 0.
R01 a 0 200
R02 a 0 200
R03 a 0 200
R04 a 0 200
R05 a 0 200
R06 a 0 200
R07 a 0 200
R08 a 0 200
R09 a 0 200
R10 a 0 200
R11 a 0 200
R12 a 0 200
R13 a 0 200
R14 a 0 200
R15 a 0 200
R16 a 0 200
R17 a 0 200
R18 a 0 200
R19 a 0 200
R20 a 0 200
R21 a 0 200
R22 a 0 200
R23 a 0 200
R24 a 0 200
R25 a 0 200
R26 a 0 200
R27 a 0 200
R28 a 0 200
R29 a 0 200
R30 a 0 200
R31 a 0 200
R32 a 0 200
R33 a 0 200
R34 a 0 200
R35 a 0 200
R36 a 0 200
R37 a 0 200
R38 a 0 200
R39 a 0 200
R40 a 0 200
R41 a 0 200
R42 a 0 200
R43 a 0 200
R44 a 0 200
R45 a 0 200
R46 a 0 200
R47 a 0 200
R48 a 0 200
R49 a 0 200
R50 a 0 200
