* Schaum Basic Circuit Analysis, Exercise 3.76.
* Fig. 3-33 ladder from Exercise 3.75, with all resistances doubled.
* Values are in kOhm.
R30 a top1 30
Rb12 0 bot1 12
R20 top1 bot1 20
Rt12 top1 top2 12
Rb4 bot1 bot2 4
R16 top2 bot2 16
R6 top2 top3 6
R10 bot2 bot3 10
R8 top3 bot3 8
